* fake:measure=delay=1e-09
* fake:measure=gain=2.0
.end
