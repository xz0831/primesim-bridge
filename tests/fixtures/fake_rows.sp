* fake:rows=3
* fake:measure=vout=1.0
.end
