* measure directive is supplied by an appended file
.end
